// Design: testing/netlist
simulator lang=spectre
global 0
include "/home/tech/GF/GF22FDX/Models/Spectre/models/design_wrapper.lib.scs" section=tt_pre
parameters fdenable=900m FFL_CP_gain=100u pfdenable=0 cycles=150 fdev=80M fcenter=1G fref=100M fsig=fcenter+fdev Tsim=cycles/fref

// phase_locked_loop_56GHz_model/pulser/schematic
subckt pulser vdd voutn voutp vrefn vrefp vss
parameters delay
    DELAY2 (net09 net08 net014 net07) delay td=delay gain=1.0
    DELAY0 (net07 net014 vrefn vrefp) delay td=delay gain=1.0
    E0 (voutp voutn net07 net014 net09 net08) vcvs gain=1.0 type=and
ends pulser

// testing/netlist/schematic
R0 (net1 0) resistor r=1K
C0 (net1 0) capacitor c=1p
L0 (net1 0) inductor l=1n
E0 (net1 0 0 0) vcvs gain=1.0
H0 (net1 0) ccvs rm=1.0
G0 (net1 0 0 0) vccs gm=1.0
F0 (net1 0) cccs gain=1.0
V0 (net1 0) vsource type=dc
I0 (net1 0) isource type=dc
simulatorOptions options temp=27
tran tran stop=Tsim errpreset=conservative
dcOp dc

// vim: ft=spectre
