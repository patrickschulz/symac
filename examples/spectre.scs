// Design: testing/netlist
simulator lang=spectre
global 0
include "/home/tech/GF/GF22FDX/Models/Spectre/models/design_wrapper.lib.scs" section=tt_pre

// testing/netlist/schematic
R0 (net1 0) resistor r=1K
C0 (net1 0) capacitor c=1p
L0 (net1 0) inductor l=1n
E0 (net1 0 0 0) vcvs gain=1.0
H0 (net1 0) ccvs rm=1.0
G0 (net1 0 0 0) vccs gm=1.0
F0 (net1 0) cccs gain=1.0
V0 (net1 0) vsource type=dc
I0 (net1 0) isource type=dc
simulatorOptions options temp=27
