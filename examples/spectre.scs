// Design: test/Inverter
simulator lang=spectre
global vss vdd

// test/Inverter/schematic
subckt Inverter ip_inv op_inv
    R0 (net16 op_inv) resistor r=100.0m m=1
    R1 (op_inv net17) resistor r=100.0m m=1
    M0 (net17 ip_inv vss vss) Nch w=15u l=0.35u m=1 region=triode
    M1 (net16 ip_inv vdd vdd) Pch w=20u l=0.35u m=1 region=triode
ends Inverter
