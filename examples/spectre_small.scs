simulator lang=spectre
V0 (net1 0) vsource V0
R0 (net1 0) resistor R0

.print I(VV0.n) / V(net1)
