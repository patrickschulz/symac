simulator lang=spectre
R0 (net1 0) resistor R0

simulator lang = spice
R1 net1 0 R1
V0 net1 0 vin

.print I(V0.p)
